{
  name:               "fft_core",
  human_name:         "fft_core",
  one_line_desc:      "",
  one_paragraph_desc: '''
  '''
  // Unique comportable IP identifier defined under KNOWN_CIP_IDS in the regtool.
  cip_id:             "1",
  design_spec:        "",
  dv_doc:             "",
  hw_checklist:       "",
  sw_checklist:       "",
  revisions: [
  {
    version:            "1.0.0",
    life_stage:         "",
    design_stage:       "",
    verification_stage: "",
    commit_id:          "",
    notes:              ""
  }
    ]
  clocking: [{clock: "clk_i", reset: "rst_ni"}],
  bus_interfaces: [
    { protocol: "tlul", direction: "device" }
  ],
  //available_input_list: [
  //  { name: "input_i", desc: "input" }
  //],
  //available_output_list: [
  //  { name: "output_o", desc: "output" }
  //],
  //interrupt_list: [
  //  { name: "main_interrupt",
  //    desc: "main_interrupt"}
  //],
  //alert_list: [
  //  { name: "fatal_fault",
  //    desc: '''
  //    This fatal alert is triggered when ...
  //    '''
  //  }
  //],
  //features: [
  //  { name: "feature1",
  //    desc: '''
  //      Feature 1.
  //    '''
  //  },
  //]
  //inter_signal_list: [
  //  { struct: "logic"
  //    type:   "uni"
  //    name:   "trigger"
  //    desc: '''
  //      Trigger request
  //    '''
  //    act:    "req"
  //  }
  //]
  //countermeasures: [
  //  { name: "BUS.INTEGRITY",
  //    desc: "End-to-end bus integrity scheme."
  //  }
  //]
  //param_list: [
  //  { name:    "FifoDepth",
  //    desc:    "Number of bytes in the FIFO.",
  //    type:    "int",
  //    default: "64",
  //    local:   "true",
  //  }
  //]
  regwidth: "32",
  registers: [
    { name: "CTRL",
      desc: "UART control register",
      swaccess: "rw",
      hwaccess: "hro",
      fields: [
        { bits: "0",
          name: "EN",
          desc: "enable"
        }
        { bits: "1",
          name: "RST",
          desc: "reset"
        }
        { bits: "31:16",
          name: "SETTING",
          desc: "Basic setting 16 bits."
        }
      ]
    },
    { name:     "STATUS"
      desc:     "UART live status register"
      swaccess: "ro"
      hwaccess: "hrw"
      hwext:    "true"
      hwre:     "true"
      fields: [
        { bits: "0"
          name: "FULL"
          desc: "Buffer is full"
        }
        { bits: "1"
          name: "EMPTY"
          desc: "Buffer is empty"
        }
      ]
    }
    { name: "RDATA",
      desc: "read data",
      swaccess: "ro",
      hwaccess: "hrw",
      hwext: "true",
      hwre: "true",
      fields: [
        { bits: "7:0" }
      ]
      tags: [// read wdata when fifo is empty, dut may return unknown data
             "excl:CsrAllTests:CsrExclCheck"]
    }
    { name: "WDATA",
      desc: "write data",
      swaccess: "wo",
      hwaccess: "hro",
      hwqe: "true",
      fields: [
        { bits: "7:0" }
      ]
      tags: [// don't write to wdata - it affects several other csrs
             "excl:CsrNonInitTests:CsrExclWrite"]
    }
  ]
}
