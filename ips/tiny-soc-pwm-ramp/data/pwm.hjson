// Copyright lowRISC contributors (OpenTitan project).
// Licensed under the Apache License, Version 2.0, see LICENSE for details.
// SPDX-License-Identifier: Apache-2.0
{
  name:               "pwm",
  human_name:         "Pulse Width Modulator",
  one_line_desc:      "Transmission of pulse-width modulated output signals with adjustable duty cycle",
  one_paragraph_desc: '''
  Pulse Width Modulator creates pulse-width modulated (PWM) signals with adjustable duty cycle.
  It is suitable for general-purpose use, but primarily designed for control of LEDs.
  All outputs are programmable with frequency, phase, and duty cycle.
  '''
  // Unique comportable IP identifier defined under KNOWN_CIP_IDS in the regtool.
  cip_id:             "19",
  design_spec:        "../doc",
  dv_doc:             "../doc/dv",
  hw_checklist:       "../doc/checklist",
  sw_checklist:       "/sw/device/lib/dif/dif_pwm",
  revisions: [
    {
      version:            "1.0.0",
      life_stage:         "L1",
      design_stage:       "D2S",
      verification_stage: "V2S",
      dif_stage:          "S2",
      notes:              ""
    }
  ]
  clocking: [
    {clock: "clk_i", reset: "rst_ni", primary: true}
  ]
  bus_interfaces: [
    { protocol: "tlul", direction: "device" }
  ],
  regwidth: "32",
  param_list: [
    { name: "NOutputs",
      desc: "Number of PWM outputs",
      type: "int",
      default: "1",
    }
  ]
  available_output_list: [
    { name:  "pwm"
      desc:  '''Pulse output.  Note that though this output is always enabled, there is a formal
                set of enable pins (pwm_en_o) which are required for top-level integration of
                comportable IPs.'''
      width: "1"
    }
  ]
  features: [
    { name: "PWM.DUTYCYCLE",
      desc: ''' The duty cycle of the generated pulse can be changed.
                '''
    },
    { name: "PWM.BLINK",
      desc: ''' Duty cycle switches between one programmable value and another.
                '''
    },
    { name: "PWM.HEARTBEAT",
      desc: ''' Duty cycle linearly increases from one programmable value to another.
                '''
    },
    { name: "PWM.POLARITY",
      desc: ''' PWM is active high by default, but his can be changed.
                '''
    },
    { name: "PWM.CLOCKDIVIDER",
      desc: ''' The duty cycle are set with counters, and a clock divider can be set to adjust the clock for all of these counters.
                '''
    },
    { name: "PWM.PHASEDELAY",
      desc: ''' Different PWM signals can be offset in phase.
                '''
    }
  ],
  countermeasures: [
    { name: "BUS.INTEGRITY",
      desc: "End-to-end bus integrity scheme."
    }
  ]
  registers: [
    { name: "CFG",
      desc: "Configuration register",
      swaccess: "rw",
      async: "clk_i",
      hwqe: "true",
      fields: [
        { bits: "31",
          name: "CNTR_EN",
          desc: '''Assert this bit to enable the PWM phase counter.
                   Clearing this bit disables and resets the phase counter.'''
          resval: "0x0"
        },
        { bits: "30:27",
          name: "DC_RESN"
          desc: '''Phase Resolution (logarithmic). All duty-cycle and phase
                   shift registers represent fractional PWM cycles, expressed in
                   units of 2^16 PWM cycles. Each PWM cycle  is divided
                   into 2^(DC_RESN+1) time slices, and thus only the (DC_RESN+1)
                   most significant bits of each phase or duty cycle register
                   are relevant.'''
          resval: 7
        },
        { bits: "26:0",
          name: "CLK_DIV",
          desc: '''Sets the period of each PWM beat to be (CLK_DIV+1)
                   input clock periods.  Since PWM pulses are generated once
                   every 2^(DC_RESN+1) beats, the period between output
                   pulses is 2^(DC_RESN+1)*(CLK_DIV+1) times longer than the
                   input clock period.'''
          resval: "0x00008000"
        }
      ]
    },
    { multireg: { name: "PWM_EN",
        desc: "Enable PWM operation for each channel",
        count: "NOutputs",
        swaccess: "rw",
        cname: "pwm_en",
        compact: "1",
        async: "clk_i",
        hwqe: "true",
        fields: [
          { bits: "0",
            name: "EN",
            desc: '''Write 1 to this bit to enable PWM pulses on the
                     corresponding channel.''',
            resval: "0"
          }
        ]
      }
    },
    { multireg: { name: "PWM_PARAM",
        desc: "Basic PWM Channel Parameters",
        count: "NOutputs"
        swaccess: "rw",
        cname: "pwm_params",
        async: "clk_i",
        hwqe: "true",
        fields: [
          { bits: "31:16",
            name: "DUTY_CYCLE",
            desc: '''The target duty cycle for PWM output, in units
                     of 2^(-16)ths of a pulse cycle. The actual precision is
                     however limited to the (DC_RESN+1) most significant bits.
                     This setting only applies when blinking, and determines
                     the target duty cycle.'''
            resval: "0x7fff"
          }
          { bits: "15:0",
            name: "PHASE_DELAY",
            desc: '''Phase delay of the PWM rising edge, in units of 2^(-16) PWM
                     cycles''',
            resval: "0x0000"
          }
        ]
      }
    },
    { name: "RAMP",
      desc: "Configuration register",
      swaccess: "rw",
      hwaccess: "hro",
      fields: [
        { bits: "0",
          name: "PWM_RAMP_EN",
          desc: '''Ramp generation enable.'''
          resval: "0x0"
        }
        { bits: "3:1",
          name: "PWM_RAMP_STEP",
          desc: '''Ramp step.'''
          resval: "0x1"
        }
      ]
    },
    { name:     "ADC_VALUE"
      desc:     "ADC value"
      swaccess: "ro"
      hwaccess: "hwo"
      fields: [
        { bits: "7:0"
          name: "ADC_VALUE"
          desc: "ADC value"
        }
      ]
    }
  ]
}
