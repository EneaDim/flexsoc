{
  name:               "gpio",
  human_name:         "4-bit General-Purpose I/O Controller",
  one_line_desc:      "Four-bit GPIO controller with direct I/O, interrupts, and input filtering.",
  one_paragraph_desc: '''
    Four-bit general-purpose I/O controller.
    Software can read four GPIO inputs and independently program four output
    values and four output enables. Each input supports rising-edge,
    falling-edge, active-high, and active-low interrupt detection. A per-input
    filter can require the sampled value to remain stable before it is accepted.
  '''

  cip_id:             "9",
  design_spec:        "",
  dv_doc:             "",
  hw_checklist:       "",
  sw_checklist:       "",

  revisions: [{
    version:            "1.0.0",
    life_stage:         "L0",
    design_stage:       "D0",
    verification_stage: "V0",
    commit_id:          "",
    notes:              "Initial FlexSoC 4-bit GPIO definition."
  }]

  clocking: [{ clock: "clk_i", reset: "rst_ni" }]
  bus_interfaces: [{ protocol: "tlul", direction: "device" }]
  regwidth: "32"

  registers: [
    {
      name: "DATA_IN",
      desc: "Current filtered GPIO input value.",
      swaccess: "ro",
      hwaccess: "hwo",
      fields: [
        {
          bits: "3:0",
          name: "GPIO_IN",
          desc: "Filtered input value for GPIO[3:0]."
        }
      ]
    },

    {
      name: "DIRECT",
      desc: "Direct GPIO output values and output enables.",
      swaccess: "rw",
      hwaccess: "hrw",
      hwext: "true",
      hwqe: "true",
      fields: [
        {
          bits: "3:0",
          name: "GPIO_O",
          desc: "Output value for GPIO[3:0]."
        },
        {
          bits: "7:4",
          name: "GPIO_OE",
          desc: "Output enable for GPIO[3:0]."
        }
      ]
    },

    {
      name: "INTR_CTRL",
      desc: "Per-input interrupt detection and input-filter enables.",
      swaccess: "rw",
      hwaccess: "hro",
      fields: [
        {
          bits: "3:0",
          name: "EN_RISING",
          desc: "Enable rising-edge interrupt detection for GPIO[3:0]."
        },
        {
          bits: "7:4",
          name: "EN_FALLING",
          desc: "Enable falling-edge interrupt detection for GPIO[3:0]."
        },
        {
          bits: "11:8",
          name: "EN_LVLHIGH",
          desc: "Enable active-high level interrupt detection for GPIO[3:0]."
        },
        {
          bits: "15:12",
          name: "EN_LVLLOW",
          desc: "Enable active-low level interrupt detection for GPIO[3:0]."
        },
        {
          bits: "19:16",
          name: "EN_INPUT_FILTER",
          desc: "Enable the 16-sample input filter independently for GPIO[3:0]."
        }
      ]
    }
  ]
}
